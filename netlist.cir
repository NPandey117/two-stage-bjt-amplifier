* C:\Users\nupur\OneDrive\Desktop\CE_Amplifier\2-stage_CE_Amplifier.asc
* Generated by LTspice 26.0.1 for Windows.
R1 N003 Vout1 3.6k
R2 Vout1 0 720
R3 N003 N005 150
R4 P001 N007 3
R5 N007 0 27
R6 Vout 0 1.5k
C1 Vout N005 10µ
C3 0 N007 1000µ
Q1 N005 Vout1 P001 0 2N2222
V1 N003 0 12
R7 N001 N004 7.2k
R8 N004 0 1.44k
R9 N001 N002 300
R10 N006 N008 3
R11 N008 0 57
C4 N008 0 1000µ
C5 Vout1 N002 47µ
C7 N004 Vin 47µ
Q2 N002 N004 N006 0 2N2222
V3 Vin 0 SINE(0 2.2m 1k) AC 1 Rser=50
V4 N001 0 12
.model NPN NPN
.model PNP PNP
.lib C:\Users\nupur\AppData\Local\LTspice\lib\cmp\standard.bjt
* .tran 5m
.ac dec 100 1 1000Meg
.backanno
.end
